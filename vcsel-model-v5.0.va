// VerilogA model for VCSEL, Version 5.0
// Created by Arijit Karmakar, IMEC-Ghent University
// This work is supported in part by the European Commission through the Horizon Europe project `Sprinter' under grant agreement number 101070581.

`include "constants.vams"
`include "disciplines.vams"

module VCSELmodel_v5(Anode, Cathode, Popt);

inout Anode, Cathode;
output Popt;
electrical Anode, Cathode, Popt, popt_intr,n1,nL,n2,Junc;

ground gnd;

  	real Iv; //VCSEL current
	real Rtemp = 1m; // intermediate resistance [Ohm]
	real V_De;//thermally induced voltage error terms
	real n_diode; // heterojunction diode ideality factor
	real Is; //saturation current
	real Rm; // DBR + contact resistances
	real Ra; // active junction resistance
	real Ca;// active junction capacitance
	real Cp = 42f, Rp = 20; //pad parasitic
	real Lp = 20p; //pad inductance
	real ith0; // threshold current
	real n_popt; // slope efficiency
	real P_V; // Converted optical power
	real P_Ve; // thermally induced optical power error terms
	real K,fr, gamma, gamma0 = 1.2e10; // optical resonance prameters
	real Copt = 100f, Lopt, Ropt; // optical equivalent lumped elements

	real pCa[2:0],pRa[2:0], pRm[1:0], pfr[2:0], verr[3:0], perr[2:0];
	real T; // temperature in degC
	real pole_thermal[0:1]={-1/1e-6, 0};//thermal time constant [s]

	branch (Junc, Cathode) Rjunc, Cjunc;

	analog initial begin
		T = $temperature-`P_CELSIUS0;
		n_diode = 3.8-3e-2*T+3e-4*pow(T,2)-1.03e-6*pow(T,3);
		Is=1.76e-12+7e-9*exp(-582/T);
		ith0 = 3.68e-04+7.86e-07*T+3.17e-8*pow(T,2);
		n_popt = 0.59-6.3e-04*T-3.9e-06*pow(T,2);
		K = (8e-3*T+2.621);

		pCa[2] = 1e-10*(-2.95e-5*pow(T,3)+7.73e-3*pow(T,2)-0.36*T+3.87);
		pCa[1] = 1e-12*(2.6e-5*pow(T,3)-4.63e-3*pow(T,2)+0.15*T+2.44);
		pCa[0] = 1e-14*(1.28e-5*pow(T,3)-2e-3*pow(T,2)+0.17*T+6);

		pRa[2] = (7.25e-04*pow(T,3)-0.3*pow(T,2)+38.5*T-4955);
		pRa[1] = (-1.5e-07*pow(T,3)+2e-05*pow(T,2) -1.85e-03*T+0.134);
		pRa[0] = (3.3e-07*pow(T,3)+3.4e-03*pow(T,2)-1.5*T+ 130);

		pRm[1] = (1.28*T+585);
		pRm[0] = (0.14*T+26);

		verr[3] = -7.75*pow(T,2) -1095*T + 124000;
		verr[2] = -7.25e-04*pow(T,3) +0.28*pow(T,2)+34*T-3200;
		verr[1] = -4.4e-04*pow(T,2)-0.4*T+18;
		verr[0] = 1e-07*pow(T,3)-2e-05*pow(T,2)+1.85e-03*T-0.13;

		pfr[2] = (-7.8e6*pow(T,2)+4.35e9*T-1.8e12);
		pfr[1] = (-7.9e5*pow(T,2)-1.26e9*T+4.3e11);
		pfr[0] = 2e7*T-1.266e9;

		perr[2] = (18-1.5e-2*T-2.2e-3*pow(T,2));
		perr[1] = (-2825-20*T+0.2*pow(T,2));
		perr[0] = (51300+740*T-4.5*pow(T,2));
	end

   analog begin

	I(Anode, n1) <+ V(Anode, n1)/Rtemp;
	I(Anode,n2) <+ Cp*ddt(V(Anode,n2));
	I(n2,Cathode) <+ V(n2,Cathode)/Rp;
	Iv = I(Anode, n1);

	//To compute input parasitic
	Ca = pCa[2]*pow(Iv,2)+pCa[1]*Iv+pCa[0];
	Ra = pRa[2]*Iv+pRa[1]/Iv+pRa[0];
	Rm = pRm[1]*Iv+pRm[0];

	//To compute thermally settled error in VCSEL voltage
	V_De=laplace_np(verr[3]*pow(Iv,3)+verr[2]*pow(Iv,2)+verr[1]*Iv+verr[0],{1},pole_thermal);// low-pass filtering

	V(n1,Junc) <+ Lp*ddt(I(n1,Junc))+I(n1,Junc)*Rm;
	I(Cjunc) <+ Ca*ddt(V(Cjunc));
	V(Rjunc) <+ I(Rjunc)*Ra+n_diode*$vt(T+273)*$ln(I(Rjunc)/Is+1) + V_De;

	//To compute optical response parameters
	fr = pfr[2]*abs(Iv-ith0)+ pfr[1]*sqrt(Iv-ith0)+pfr[0];
	gamma = K*pow(fr/1e5,2)+gamma0;
	Lopt = 1/pow(2*`M_PI*fr,2)/Copt;
	Ropt = Lopt*gamma;

	//To compute thermally settled error in VCSEL optical power
	P_Ve = laplace_np(perr[0]*pow(Iv,4)+perr[1]*pow(Iv,3)+perr[2]*pow(Iv,2),{1},pole_thermal);// low-pass filtering

	P_V = n_popt*(Iv-ith0); // Electro-optical power conversion
	V(popt_intr,gnd) <+ (P_V + P_Ve)*0.5*(1.0+tanh(1e6*(P_V + P_Ve))); //Correction for negative power

	//VCSEL non linearity; Optical equivalent electrical lumped elements
	V(Popt,gnd) <+ V(popt_intr,gnd) - Ropt*I(popt_intr,Popt) - Lopt*ddt(I(popt_intr,Popt));
	I(popt_intr,Popt) <+ Copt*ddt(V(Popt,gnd));
   end
endmodule
